CIRCUIT C:\bin\mw-tools\Export Microwind\examples\1\chip.msk
*
* IC Technology: standard 1.0µm
*
VDD 1 0 DC  5.0
*
* List of nodes
* "Diode(11)" corresponds to n°3
* "N4" corresponds to n°4
* "Vbias" corresponds to n°5
* "E" corresponds to n°6
* "QGOD" corresponds to n°7
* "Q" corresponds to n°8
* "AOP(5)" corresponds to n°9
* "RingOsc(6)" corresponds to n°10
* "Hout1024" corresponds to n°16
* "Hout4096" corresponds to n°17
* "Hout64" corresponds to n°18
* "Hout256" corresponds to n°19
* "Hout4" corresponds to n°20
* "Hout16" corresponds to n°21
* "D" corresponds to n°28
* "Set" corresponds to n°83
* "Light(15)" corresponds to n°90
* "Hin" corresponds to n°91
* "Ex2(1)" corresponds to n°98
* "N100" corresponds to n°100
* "N101" corresponds to n°101
* "N102" corresponds to n°102
* "r" corresponds to n°103
* "N104" corresponds to n°104
* "N105" corresponds to n°105
* "N106" corresponds to n°106
* "N107" corresponds to n°107
* "N108" corresponds to n°108
* "Q1" corresponds to n°109
* "Q2(3)" corresponds to n°110
* "Q3" corresponds to n°111
* "N112" corresponds to n°112
* "N113" corresponds to n°113
* "N114" corresponds to n°114
* "N115" corresponds to n°115
* "N116" corresponds to n°116
* "N117" corresponds to n°117
* "N118" corresponds to n°118
* "N119" corresponds to n°119
* "N120" corresponds to n°120
* "N121" corresponds to n°121
* "N122" corresponds to n°122
* "N123" corresponds to n°123
* "N124" corresponds to n°124
* "N125" corresponds to n°125
* "N126" corresponds to n°126
* "N127" corresponds to n°127
* "N128" corresponds to n°128
* "N129" corresponds to n°129
* "N130" corresponds to n°130
* "N131" corresponds to n°131
* "N132" corresponds to n°132
* "N133" corresponds to n°133
* "N134" corresponds to n°134
* "N135" corresponds to n°135
* "N136" corresponds to n°136
* "N137" corresponds to n°137
* "N138" corresponds to n°138
* "N139" corresponds to n°139
* "N140" corresponds to n°140
* "N141" corresponds to n°141
* "N142" corresponds to n°142
* "N143" corresponds to n°143
* "Y" corresponds to n°144
* "N145" corresponds to n°145
* "N146" corresponds to n°146
* "N147" corresponds to n°147
* "EX1(28)" corresponds to n°148
* "N149" corresponds to n°149
* "N150" corresponds to n°150
* "N151" corresponds to n°151
* "N152" corresponds to n°152
* "N153" corresponds to n°153
* "N154" corresponds to n°154
* "N155" corresponds to n°155
* "N156" corresponds to n°156
* "N157" corresponds to n°157
* "Noise" corresponds to n°158
* "N159" corresponds to n°159
* "N160" corresponds to n°160
* "DP(17)" corresponds to n°161
* "A" corresponds to n°162
* "N163" corresponds to n°163
* "OutTGate(23)" corresponds to n°164
* "N165" corresponds to n°165
* "N166" corresponds to n°166
* "Nor3(25)" corresponds to n°167
* "Nand2" corresponds to n°168
* "XOR" corresponds to n°169
* "N170" corresponds to n°170
* "N171" corresponds to n°171
* "InvA(21)" corresponds to n°172
* "N173" corresponds to n°173
* "N174" corresponds to n°174
* "Set" corresponds to n°175
* "N176" corresponds to n°176
* "N177" corresponds to n°177
* "N178" corresponds to n°178
* "N179" corresponds to n°179
* "N180" corresponds to n°180
* "N181" corresponds to n°181
* "N182" corresponds to n°182
* "N183" corresponds to n°183
* "DN(19)" corresponds to n°184
* "DNBig(20)" corresponds to n°185
* "N186" corresponds to n°186
* "InvE(22)" corresponds to n°187
*
* MOS devices
MN1 9 14 5 0 TN  W=77.50U L= 1.00U
MN2 174 175 8 0 TN  W= 3.00U L= 1.00U
MN3 173 83 7 0 TN  W= 3.00U L= 1.00U
MN4 5 11 173 0 TN  W= 3.00U L= 1.00U
MN5 5 12 174 0 TN  W= 3.00U L= 1.00U
MN6 175 6 28 0 TN  W= 3.00U L= 1.00U
MN7 176 7 11 0 TN  W= 3.00U L= 1.00U
MN8 177 8 12 0 TN  W= 3.00U L= 1.00U
MN9 5 17 10 0 TN  W=18.00U L= 1.00U
MN10 5 103 176 0 TN  W= 3.00U L= 1.00U
MN11 5 103 177 0 TN  W= 3.00U L= 1.00U
MN12 14 14 5 0 TN  W=10.00U L= 1.00U
MN13 178 28 13 0 TN  W=10.00U L= 1.00U
MN14 5 162 178 0 TN  W= 9.00U L= 1.00U
MN15 15 6 178 0 TN  W=10.00U L= 1.00U
MN16 16 53 29 0 TN  W= 3.00U L= 1.00U
MN17 17 54 30 0 TN  W= 3.00U L= 1.00U
MN18 18 55 31 0 TN  W= 3.00U L= 1.00U
MN19 19 56 32 0 TN  W= 3.00U L= 1.00U
MN20 20 57 33 0 TN  W= 3.00U L= 1.00U
MN21 21 58 34 0 TN  W= 3.00U L= 1.00U
MN22 5 22 16 0 TN  W= 3.00U L= 1.00U
MN23 5 23 17 0 TN  W= 3.00U L= 1.00U
MN24 5 24 18 0 TN  W= 3.00U L= 1.00U
MN25 5 25 19 0 TN  W= 3.00U L= 1.00U
MN26 5 26 20 0 TN  W= 3.00U L= 1.00U
MN27 5 27 21 0 TN  W= 3.00U L= 1.00U
MN28 5 29 22 0 TN  W= 3.00U L= 1.00U
MN29 5 30 23 0 TN  W= 3.00U L= 1.00U
MN30 5 31 24 0 TN  W= 3.00U L= 1.00U
MN31 5 32 25 0 TN  W= 3.00U L= 1.00U
MN32 5 33 26 0 TN  W= 3.00U L= 1.00U
MN33 5 34 27 0 TN  W= 3.00U L= 1.00U
MN34 5 47 35 0 TN  W= 3.00U L= 1.00U
MN35 5 48 36 0 TN  W= 3.00U L= 1.00U
MN36 5 49 37 0 TN  W= 3.00U L= 1.00U
MN37 5 50 38 0 TN  W= 3.00U L= 1.00U
MN38 5 51 39 0 TN  W= 3.00U L= 1.00U
MN39 5 52 40 0 TN  W= 3.00U L= 1.00U
MN40 5 41 47 0 TN  W= 3.00U L= 1.00U
MN41 5 42 48 0 TN  W= 3.00U L= 1.00U
MN42 5 43 49 0 TN  W= 3.00U L= 1.00U
MN43 5 44 50 0 TN  W= 3.00U L= 1.00U
MN44 5 45 51 0 TN  W= 3.00U L= 1.00U
MN45 5 46 52 0 TN  W= 3.00U L= 1.00U
MN46 22 53 41 0 TN  W= 3.00U L= 1.00U
MN47 23 54 42 0 TN  W= 3.00U L= 1.00U
MN48 24 55 43 0 TN  W= 3.00U L= 1.00U
MN49 25 56 44 0 TN  W= 3.00U L= 1.00U
MN50 26 57 45 0 TN  W= 3.00U L= 1.00U
MN51 27 58 46 0 TN  W= 3.00U L= 1.00U
MN52 53 19 65 0 TN  W= 3.00U L= 1.00U
MN53 54 16 66 0 TN  W= 3.00U L= 1.00U
MN54 55 21 67 0 TN  W= 3.00U L= 1.00U
MN55 56 18 68 0 TN  W= 3.00U L= 1.00U
MN56 57 91 69 0 TN  W= 3.00U L= 1.00U
MN57 58 20 70 0 TN  W= 3.00U L= 1.00U
MN58 5 59 53 0 TN  W= 3.00U L= 1.00U
MN59 5 60 54 0 TN  W= 3.00U L= 1.00U
MN60 5 61 55 0 TN  W= 3.00U L= 1.00U
MN61 5 62 56 0 TN  W= 3.00U L= 1.00U
MN62 5 63 57 0 TN  W= 3.00U L= 1.00U
MN63 5 64 58 0 TN  W= 3.00U L= 1.00U
MN64 5 65 59 0 TN  W= 3.00U L= 1.00U
MN65 5 66 60 0 TN  W= 3.00U L= 1.00U
MN66 5 67 61 0 TN  W= 3.00U L= 1.00U
MN67 5 68 62 0 TN  W= 3.00U L= 1.00U
MN68 5 69 63 0 TN  W= 3.00U L= 1.00U
MN69 5 70 64 0 TN  W= 3.00U L= 1.00U
MN70 5 84 71 0 TN  W= 3.00U L= 1.00U
MN71 5 85 72 0 TN  W= 3.00U L= 1.00U
MN72 5 86 73 0 TN  W= 3.00U L= 1.00U
MN73 5 87 74 0 TN  W= 3.00U L= 1.00U
MN74 5 88 75 0 TN  W= 3.00U L= 1.00U
MN75 5 89 76 0 TN  W= 3.00U L= 1.00U
MN76 5 77 84 0 TN  W= 3.00U L= 1.00U
MN77 5 78 85 0 TN  W= 3.00U L= 1.00U
MN78 5 79 86 0 TN  W= 3.00U L= 1.00U
MN79 5 80 87 0 TN  W= 3.00U L= 1.00U
MN80 5 81 88 0 TN  W= 3.00U L= 1.00U
MN81 5 82 89 0 TN  W= 3.00U L= 1.00U
MN82 59 19 77 0 TN  W= 3.00U L= 1.00U
MN83 60 16 78 0 TN  W= 3.00U L= 1.00U
MN84 61 21 79 0 TN  W= 3.00U L= 1.00U
MN85 62 18 80 0 TN  W= 3.00U L= 1.00U
MN86 63 91 81 0 TN  W= 3.00U L= 1.00U
MN87 64 20 82 0 TN  W= 3.00U L= 1.00U
MN88 93 92 5 0 TN  W= 3.00U L= 3.00U
MN89 5 94 91 0 TN  W= 3.00U L= 3.00U
MN90 5 95 92 0 TN  W= 3.00U L= 3.00U
MN91 96 93 5 0 TN  W= 3.00U L= 3.00U
MN92 5 99 94 0 TN  W= 3.00U L= 3.00U
MN93 5 100 95 0 TN  W= 3.00U L= 3.00U
MN94 179 28 98 0 TN  W= 3.00U L= 1.00U
MN95 5 83 179 0 TN  W= 3.00U L= 1.00U
MN96 101 96 5 0 TN  W= 3.00U L= 3.00U
MN97 102 109 5 0 TN  W= 3.00U L= 1.00U
MN98 180 6 179 0 TN  W= 3.00U L= 1.00U
MN99 5 105 99 0 TN  W= 3.00U L= 3.00U
MN100 5 106 100 0 TN  W= 3.00U L= 3.00U
MN101 180 103 98 0 TN  W= 3.00U L= 1.00U
MN102 5 162 180 0 TN  W= 3.00U L= 1.00U
MN103 104 111 109 0 TN  W= 3.00U L= 1.00U
MN104 107 101 5 0 TN  W= 3.00U L= 3.00U
MN105 5 112 105 0 TN  W= 3.00U L= 3.00U
MN106 5 113 106 0 TN  W= 3.00U L= 3.00U
MN107 108 104 5 0 TN  W= 3.00U L= 1.00U
MN108 109 6 118 0 TN  W= 3.00U L= 1.00U
MN109 110 6 122 0 TN  W= 3.00U L= 1.00U
MN110 111 6 124 0 TN  W= 3.00U L= 1.00U
MN111 5 115 109 0 TN  W= 3.00U L= 1.00U
MN112 5 116 110 0 TN  W= 3.00U L= 1.00U
MN113 114 107 5 0 TN  W= 3.00U L= 3.00U
MN114 5 117 111 0 TN  W= 3.00U L= 1.00U
MN115 5 119 112 0 TN  W= 3.00U L= 3.00U
MN116 5 120 113 0 TN  W= 3.00U L= 3.00U
MN117 5 118 115 0 TN  W= 3.00U L= 1.00U
MN118 5 122 116 0 TN  W= 3.00U L= 1.00U
MN119 5 124 117 0 TN  W= 3.00U L= 1.00U
MN120 121 114 5 0 TN  W= 3.00U L= 3.00U
MN121 5 130 119 0 TN  W= 3.00U L= 3.00U
MN122 5 131 120 0 TN  W= 3.00U L= 3.00U
MN123 132 121 5 0 TN  W= 3.00U L= 3.00U
MN124 5 133 123 0 TN  W= 3.00U L= 1.00U
MN125 5 134 125 0 TN  W= 3.00U L= 1.00U
MN126 5 135 127 0 TN  W= 3.00U L= 1.00U
MN127 5 136 130 0 TN  W= 3.00U L= 3.00U
MN128 5 137 131 0 TN  W= 3.00U L= 3.00U
MN129 5 126 133 0 TN  W= 3.00U L= 1.00U
MN130 5 128 134 0 TN  W= 3.00U L= 1.00U
MN131 138 132 5 0 TN  W= 3.00U L= 3.00U
MN132 5 129 135 0 TN  W= 3.00U L= 1.00U
MN133 5 141 136 0 TN  W= 3.00U L= 3.00U
MN134 139 108 5 0 TN  W= 3.00U L= 1.00U
MN135 5 142 137 0 TN  W= 3.00U L= 3.00U
MN136 144 6 126 0 TN  W= 3.00U L= 1.00U
MN137 109 6 128 0 TN  W= 3.00U L= 1.00U
MN138 110 6 129 0 TN  W= 3.00U L= 1.00U
MN139 140 28 108 0 TN  W= 3.00U L= 1.00U
MN140 143 138 5 0 TN  W= 3.00U L= 3.00U
MN141 5 145 141 0 TN  W= 3.00U L= 3.00U
MN142 5 146 142 0 TN  W= 3.00U L= 3.00U
MN143 144 140 5 0 TN  W= 3.00U L= 1.00U
MN144 147 143 5 0 TN  W= 3.00U L= 3.00U
MN145 5 149 145 0 TN  W= 3.00U L= 3.00U
MN146 5 150 146 0 TN  W= 3.00U L= 3.00U
MN147 151 147 5 0 TN  W= 3.00U L= 3.00U
MN148 5 152 148 0 TN  W=15.00U L= 1.00U
MN149 5 155 149 0 TN  W= 3.00U L= 3.00U
MN150 5 153 150 0 TN  W= 3.00U L= 3.00U
MN151 159 160 152 0 TN  W=15.00U L= 1.00U
MN152 156 162 153 0 TN  W= 3.00U L= 1.00U
MN153 157 151 5 0 TN  W= 3.00U L= 3.00U
MN154 5 157 155 0 TN  W= 3.00U L= 3.00U
MN155 5 94 156 0 TN  W= 3.00U L= 3.00U
MN156 5 159 154 0 TN  W=15.00U L= 1.00U
MN157 5 162 158 0 TN  W=18.00U L= 1.00U
MN158 181 162 159 0 TN  W=15.00U L= 1.00U
MN159 5 103 181 0 TN  W=15.00U L= 1.00U
MN160 182 28 160 0 TN  W=15.00U L= 1.00U
MN161 5 83 182 0 TN  W=15.00U L= 1.00U
MN162 163 6 5 0 TN  W= 3.00U L= 1.00U
MN163 164 103 162 0 TN  W= 6.00U L= 1.00U
MN164 165 28 5 0 TN  W= 3.00U L= 1.00U
MN165 166 6 28 0 TN  W= 3.00U L= 1.00U
MN166 5 83 167 0 TN  W= 3.00U L= 1.00U
MN167 169 166 5 0 TN  W= 3.00U L= 1.00U
MN168 183 83 168 0 TN  W= 3.00U L= 1.00U
MN169 167 103 5 0 TN  W= 3.00U L= 1.00U
MN170 5 103 183 0 TN  W= 3.00U L= 1.00U
MN171 5 162 167 0 TN  W= 3.00U L= 1.00U
MN172 172 162 5 0 TN  W=18.00U L= 1.00U
MN173 184 162 103 0 TN  W= 6.00U L= 1.00U
MN174 185 162 103 0 TN  W=12.00U L= 1.00U
MP1 7 83 2 2 TP  W= 7.50U L= 1.00U
MP2 8 175 2 2 TP  W= 7.50U L= 1.00U
MP3 2 11 7 2 TP  W= 7.50U L= 1.00U
MP4 2 12 8 2 TP  W= 7.50U L= 1.00U
MP5 9 13 2 2 TP  W=165.00U L= 1.00U
MP6 11 7 2 2 TP  W= 7.50U L= 1.00U
MP7 12 8 2 2 TP  W= 7.50U L= 1.00U
MP8 2 17 10 2 TP  W=32.50U L= 1.00U
MP9 2 103 11 2 TP  W= 7.50U L= 1.00U
MP10 2 103 12 2 TP  W= 7.50U L= 1.00U
MP11 13 13 2 2 TP  W=16.50U L= 1.00U
MP12 2 15 14 2 TP  W=16.50U L= 1.00U
MP13 15 15 2 2 TP  W=16.50U L= 1.00U
MP14 2 22 16 2 TP  W= 7.50U L= 1.00U
MP15 2 23 17 2 TP  W= 7.50U L= 1.00U
MP16 2 24 18 2 TP  W= 7.50U L= 1.00U
MP17 2 25 19 2 TP  W= 7.50U L= 1.00U
MP18 2 26 20 2 TP  W= 7.50U L= 1.00U
MP19 2 27 21 2 TP  W= 7.50U L= 1.00U
MP20 2 29 22 2 TP  W= 7.50U L= 1.00U
MP21 2 30 23 2 TP  W= 7.50U L= 1.00U
MP22 2 31 24 2 TP  W= 7.50U L= 1.00U
MP23 2 32 25 2 TP  W= 7.50U L= 1.00U
MP24 2 33 26 2 TP  W= 7.50U L= 1.00U
MP25 2 34 27 2 TP  W= 7.50U L= 1.00U
MP26 35 53 29 2 TP  W= 3.00U L= 1.00U
MP27 36 54 30 2 TP  W= 3.00U L= 1.00U
MP28 37 55 31 2 TP  W= 3.00U L= 1.00U
MP29 38 56 32 2 TP  W= 3.00U L= 1.00U
MP30 39 57 33 2 TP  W= 3.00U L= 1.00U
MP31 40 58 34 2 TP  W= 3.00U L= 1.00U
MP32 41 53 35 2 TP  W= 3.00U L= 1.00U
MP33 42 54 36 2 TP  W= 3.00U L= 1.00U
MP34 43 55 37 2 TP  W= 3.00U L= 1.00U
MP35 44 56 38 2 TP  W= 3.00U L= 1.00U
MP36 45 57 39 2 TP  W= 3.00U L= 1.00U
MP37 46 58 40 2 TP  W= 3.00U L= 1.00U
MP38 2 47 35 2 TP  W= 7.50U L= 1.00U
MP39 2 48 36 2 TP  W= 7.50U L= 1.00U
MP40 2 49 37 2 TP  W= 7.50U L= 1.00U
MP41 2 50 38 2 TP  W= 7.50U L= 1.00U
MP42 2 51 39 2 TP  W= 7.50U L= 1.00U
MP43 2 52 40 2 TP  W= 7.50U L= 1.00U
MP44 2 41 47 2 TP  W= 7.50U L= 1.00U
MP45 2 42 48 2 TP  W= 7.50U L= 1.00U
MP46 2 43 49 2 TP  W= 7.50U L= 1.00U
MP47 2 44 50 2 TP  W= 7.50U L= 1.00U
MP48 2 45 51 2 TP  W= 7.50U L= 1.00U
MP49 2 46 52 2 TP  W= 7.50U L= 1.00U
MP50 2 59 53 2 TP  W= 7.50U L= 1.00U
MP51 2 60 54 2 TP  W= 7.50U L= 1.00U
MP52 2 61 55 2 TP  W= 7.50U L= 1.00U
MP53 2 62 56 2 TP  W= 7.50U L= 1.00U
MP54 2 63 57 2 TP  W= 7.50U L= 1.00U
MP55 2 64 58 2 TP  W= 7.50U L= 1.00U
MP56 2 65 59 2 TP  W= 7.50U L= 1.00U
MP57 2 66 60 2 TP  W= 7.50U L= 1.00U
MP58 2 67 61 2 TP  W= 7.50U L= 1.00U
MP59 2 68 62 2 TP  W= 7.50U L= 1.00U
MP60 2 69 63 2 TP  W= 7.50U L= 1.00U
MP61 2 70 64 2 TP  W= 7.50U L= 1.00U
MP62 71 19 65 2 TP  W= 3.00U L= 1.00U
MP63 72 16 66 2 TP  W= 3.00U L= 1.00U
MP64 73 21 67 2 TP  W= 3.00U L= 1.00U
MP65 74 18 68 2 TP  W= 3.00U L= 1.00U
MP66 75 91 69 2 TP  W= 3.00U L= 1.00U
MP67 76 20 70 2 TP  W= 3.00U L= 1.00U
MP68 77 19 71 2 TP  W= 3.00U L= 1.00U
MP69 78 16 72 2 TP  W= 3.00U L= 1.00U
MP70 79 21 73 2 TP  W= 3.00U L= 1.00U
MP71 80 18 74 2 TP  W= 3.00U L= 1.00U
MP72 81 91 75 2 TP  W= 3.00U L= 1.00U
MP73 82 20 76 2 TP  W= 3.00U L= 1.00U
MP74 2 84 71 2 TP  W= 7.50U L= 1.00U
MP75 2 85 72 2 TP  W= 7.50U L= 1.00U
MP76 2 86 73 2 TP  W= 7.50U L= 1.00U
MP77 2 87 74 2 TP  W= 7.50U L= 1.00U
MP78 2 88 75 2 TP  W= 7.50U L= 1.00U
MP79 2 89 76 2 TP  W= 7.50U L= 1.00U
MP80 2 77 84 2 TP  W= 7.50U L= 1.00U
MP81 2 78 85 2 TP  W= 7.50U L= 1.00U
MP82 2 79 86 2 TP  W= 7.50U L= 1.00U
MP83 2 80 87 2 TP  W= 7.50U L= 1.00U
MP84 2 81 88 2 TP  W= 7.50U L= 1.00U
MP85 2 82 89 2 TP  W= 7.50U L= 1.00U
MP86 93 92 2 2 TP  W= 3.00U L= 3.00U
MP87 2 94 91 2 TP  W= 3.00U L= 3.00U
MP88 2 95 92 2 TP  W= 3.00U L= 3.00U
MP89 96 93 2 2 TP  W= 3.00U L= 3.00U
MP90 2 99 94 2 TP  W= 3.00U L= 3.00U
MP91 2 100 95 2 TP  W= 3.00U L= 3.00U
MP92 101 96 2 2 TP  W= 3.00U L= 3.00U
MP93 97 162 2 2 TP  W= 8.00U L= 1.00U
MP94 98 83 97 2 TP  W= 8.00U L= 1.00U
MP95 102 109 2 2 TP  W= 5.00U L= 1.00U
MP96 2 105 99 2 TP  W= 3.00U L= 3.00U
MP97 2 106 100 2 TP  W= 3.00U L= 3.00U
MP98 97 103 2 2 TP  W= 8.00U L= 1.00U
MP99 98 28 97 2 TP  W= 8.00U L= 1.00U
MP100 104 111 102 2 TP  W= 5.00U L= 1.00U
MP101 107 101 2 2 TP  W= 3.00U L= 3.00U
MP102 2 112 105 2 TP  W= 3.00U L= 3.00U
MP103 2 113 106 2 TP  W= 3.00U L= 3.00U
MP104 108 104 2 2 TP  W= 5.00U L= 1.00U
MP105 2 115 109 2 TP  W= 7.50U L= 1.00U
MP106 2 116 110 2 TP  W= 7.50U L= 1.00U
MP107 114 107 2 2 TP  W= 3.00U L= 3.00U
MP108 2 117 111 2 TP  W= 7.50U L= 1.00U
MP109 2 119 112 2 TP  W= 3.00U L= 3.00U
MP110 2 120 113 2 TP  W= 3.00U L= 3.00U
MP111 2 118 115 2 TP  W= 7.50U L= 1.00U
MP112 2 122 116 2 TP  W= 7.50U L= 1.00U
MP113 2 124 117 2 TP  W= 7.50U L= 1.00U
MP114 121 114 2 2 TP  W= 3.00U L= 3.00U
MP115 123 6 118 2 TP  W= 3.00U L= 1.00U
MP116 2 130 119 2 TP  W= 3.00U L= 3.00U
MP117 125 6 122 2 TP  W= 3.00U L= 1.00U
MP118 2 131 120 2 TP  W= 3.00U L= 3.00U
MP119 127 6 124 2 TP  W= 3.00U L= 1.00U
MP120 126 6 123 2 TP  W= 3.00U L= 1.00U
MP121 128 6 125 2 TP  W= 3.00U L= 1.00U
MP122 129 6 127 2 TP  W= 3.00U L= 1.00U
MP123 132 121 2 2 TP  W= 3.00U L= 3.00U
MP124 2 133 123 2 TP  W= 7.50U L= 1.00U
MP125 2 134 125 2 TP  W= 7.50U L= 1.00U
MP126 2 135 127 2 TP  W= 7.50U L= 1.00U
MP127 2 136 130 2 TP  W= 3.00U L= 3.00U
MP128 2 137 131 2 TP  W= 3.00U L= 3.00U
MP129 2 126 133 2 TP  W= 7.50U L= 1.00U
MP130 2 128 134 2 TP  W= 7.50U L= 1.00U
MP131 138 132 2 2 TP  W= 3.00U L= 3.00U
MP132 2 129 135 2 TP  W= 7.50U L= 1.00U
MP133 2 141 136 2 TP  W= 3.00U L= 3.00U
MP134 139 108 2 2 TP  W= 5.00U L= 1.00U
MP135 2 142 137 2 TP  W= 3.00U L= 3.00U
MP136 140 28 139 2 TP  W= 5.00U L= 1.00U
MP137 143 138 2 2 TP  W= 3.00U L= 3.00U
MP138 2 145 141 2 TP  W= 3.00U L= 3.00U
MP139 2 146 142 2 TP  W= 3.00U L= 3.00U
MP140 144 140 2 2 TP  W= 5.00U L= 1.00U
MP141 147 143 2 2 TP  W= 3.00U L= 3.00U
MP142 2 149 145 2 TP  W= 3.00U L= 3.00U
MP143 2 150 146 2 TP  W= 3.00U L= 3.00U
MP144 151 147 2 2 TP  W= 3.00U L= 3.00U
MP145 2 152 148 2 TP  W=15.00U L= 1.00U
MP146 2 155 149 2 TP  W= 3.00U L= 3.00U
MP147 2 153 150 2 TP  W= 3.00U L= 3.00U
MP148 154 160 152 2 TP  W=15.00U L= 1.00U
MP149 156 103 153 2 TP  W= 3.00U L= 1.00U
MP150 157 151 2 2 TP  W= 3.00U L= 3.00U
MP151 2 157 155 2 TP  W= 3.00U L= 3.00U
MP152 2 94 156 2 TP  W= 3.00U L= 3.00U
MP153 2 159 154 2 TP  W=15.00U L= 1.00U
MP154 2 162 158 2 TP  W=32.50U L= 1.00U
MP155 159 162 2 2 TP  W=15.00U L= 1.00U
MP156 2 103 159 2 TP  W=15.00U L= 1.00U
MP157 160 28 2 2 TP  W=15.00U L= 1.00U
MP158 2 83 160 2 TP  W=15.00U L= 1.00U
MP159 103 162 161 2 TP  W=16.00U L= 1.00U
MP160 163 6 2 2 TP  W= 7.50U L= 1.00U
MP161 164 83 162 2 TP  W=13.00U L= 1.00U
MP162 165 28 2 2 TP  W= 5.00U L= 1.00U
MP163 166 6 165 2 TP  W= 5.00U L= 1.00U
MP164 170 83 167 2 TP  W= 7.50U L= 1.00U
MP165 169 166 2 2 TP  W= 5.00U L= 1.00U
MP166 2 83 168 2 TP  W= 7.50U L= 1.00U
MP167 171 103 170 2 TP  W= 7.50U L= 1.00U
MP168 168 103 2 2 TP  W= 7.50U L= 1.00U
MP169 2 162 171 2 TP  W= 7.50U L= 1.00U
MP170 172 162 2 2 TP  W=32.50U L= 1.00U
*
C2 2 0 35960.362fF
C3 3 0 434.900fF
C4 4 0 6381.300fF
C5 5 0 5568.000fF
C6 6 0 272.549fF
C7 7 0 82.021fF
C8 8 0 82.180fF
C9 9 0 770.400fF
C10 10 0 246.600fF
C11 11 0 75.184fF
C12 12 0 75.184fF
C13 13 0 425.290fF
C14 14 0 189.131fF
C15 15 0 174.154fF
C16 16 0 107.827fF
C17 17 0 118.109fF
C18 18 0 107.827fF
C19 19 0 109.099fF
C20 20 0 107.827fF
C21 21 0 108.781fF
C22 22 0 79.050fF
C23 23 0 79.050fF
C24 24 0 79.050fF
C25 25 0 79.050fF
C26 26 0 79.050fF
C27 27 0 79.050fF
C28 28 0 295.193fF
C29 29 0 73.475fF
C30 30 0 73.475fF
C31 31 0 73.475fF
C32 32 0 73.475fF
C33 33 0 73.475fF
C34 34 0 73.475fF
C35 35 0 74.400fF
C36 36 0 74.400fF
C37 37 0 74.400fF
C38 38 0 74.400fF
C39 39 0 74.400fF
C40 40 0 74.400fF
C41 41 0 62.849fF
C42 42 0 62.849fF
C43 43 0 62.849fF
C44 44 0 62.849fF
C45 45 0 62.849fF
C46 46 0 62.849fF
C47 47 0 64.173fF
C48 48 0 64.173fF
C49 49 0 64.173fF
C50 50 0 64.173fF
C51 51 0 64.173fF
C52 52 0 64.173fF
C53 53 0 95.902fF
C54 54 0 95.902fF
C55 55 0 95.902fF
C56 56 0 95.902fF
C57 57 0 95.902fF
C58 58 0 95.902fF
C59 59 0 79.050fF
C60 60 0 79.050fF
C61 61 0 79.050fF
C62 62 0 79.050fF
C63 63 0 79.050fF
C64 64 0 79.050fF
C65 65 0 73.475fF
C66 66 0 73.475fF
C67 67 0 73.475fF
C68 68 0 73.475fF
C69 69 0 73.475fF
C70 70 0 73.475fF
C71 71 0 74.400fF
C72 72 0 74.400fF
C73 73 0 74.400fF
C74 74 0 74.400fF
C75 75 0 74.400fF
C76 76 0 74.400fF
C77 77 0 62.849fF
C78 78 0 62.849fF
C79 79 0 62.849fF
C80 80 0 62.849fF
C81 81 0 62.849fF
C82 82 0 62.849fF
C83 83 0 277.529fF
C84 84 0 64.173fF
C85 85 0 64.173fF
C86 86 0 64.173fF
C87 87 0 64.173fF
C88 88 0 64.173fF
C89 89 0 64.173fF
C90 90 0 2763.600fF
C91 91 0 97.154fF
C92 92 0 93.016fF
C93 93 0 75.844fF
C94 94 0 145.050fF
C95 95 0 75.844fF
C96 96 0 75.844fF
C97 97 0 142.200fF
C98 98 0 103.800fF
C99 99 0 75.844fF
C100 100 0 75.844fF
C101 101 0 75.844fF
C102 102 0 63.900fF
C103 103 0 434.754fF
C104 104 0 53.673fF
C105 105 0 75.844fF
C106 106 0 75.844fF
C107 107 0 75.844fF
C108 108 0 73.830fF
C109 109 0 108.218fF
C110 110 0 74.588fF
C111 111 0 91.681fF
C112 112 0 75.844fF
C113 113 0 75.844fF
C114 114 0 75.844fF
C115 115 0 64.650fF
C116 116 0 64.650fF
C117 117 0 64.650fF
C118 118 0 73.475fF
C119 119 0 75.844fF
C120 120 0 75.844fF
C121 121 0 75.844fF
C122 122 0 73.475fF
C123 123 0 74.400fF
C124 124 0 73.475fF
C125 125 0 74.400fF
C126 126 0 62.849fF
C127 127 0 74.400fF
C128 128 0 62.849fF
C129 129 0 62.849fF
C130 130 0 75.844fF
C131 131 0 75.844fF
C132 132 0 75.844fF
C133 133 0 64.173fF
C134 134 0 64.173fF
C135 135 0 64.173fF
C136 136 0 75.844fF
C137 137 0 75.844fF
C138 138 0 75.844fF
C139 139 0 63.900fF
C140 140 0 53.673fF
C141 141 0 75.844fF
C142 142 0 75.844fF
C143 143 0 75.844fF
C144 144 0 54.600fF
C145 145 0 75.844fF
C146 146 0 75.844fF
C147 147 0 75.844fF
C148 148 0 153.600fF
C149 149 0 75.844fF
C150 150 0 75.844fF
C151 151 0 75.844fF
C152 152 0 202.552fF
C153 153 0 59.819fF
C154 154 0 230.400fF
C155 155 0 75.844fF
C156 156 0 37.200fF
C157 157 0 94.500fF
C158 158 0 246.600fF
C159 159 0 356.152fF
C160 160 0 279.352fF
C161 161 0 78.900fF
C162 162 0 485.501fF
C163 163 0 47.700fF
C164 164 0 83.400fF
C165 165 0 63.900fF
C166 166 0 53.673fF
C167 167 0 66.300fF
C168 168 0 85.800fF
C169 169 0 40.200fF
C170 170 0 42.900fF
C171 171 0 42.900fF
C172 172 0 246.600fF
C173 173 0 18.600fF
C174 174 0 18.600fF
C175 175 0 37.657fF
C176 176 0 18.600fF
C177 177 0 18.600fF
C178 178 0 101.700fF
C179 179 0 45.600fF
C180 180 0 43.500fF
C181 181 0 153.600fF
C182 182 0 153.600fF
C183 183 0 18.600fF
C184 184 0 30.900fF
C185 185 0 59.700fF
C186 186 0  7.632fF
*
* n-MOS Model 3 :
*
.MODEL TN NMOS LEVEL=3 VTO=0.70 KP=40.000E-6
+LD =0.000U THETA=0.350 GAMMA=0.350
+PHI=0.680 KAPPA=0.010 VMAX=130.00K
+CGSO=  0.0p CGDO=  0.0p
*
* p-MOS Model 3:
*
.MODEL TP PMOS LEVEL=3 VTO=-0.70 KP=20.000E-6
+LD =0.000U THETA=0.350 GAMMA=0.350
+PHI=0.680 KAPPA=0.000 VMAX=100.00K
+CGSO=  0.0p CGDO=  0.0p
*
* Transient analysis
*
.TRAN 10PS 10.00N
.PROBE
.END
